# Ansys Electronics Desktop project, version 2022.1
materials:
  vacuum: permittivity=1
  steel_1008: permeability{HUnit=A_per_meter BUnit=tesla curve (0, 0) (159.2, 0.2402) (318.3, 0.8654) (477.5, 1.1106) (636.6, 1.2458) (795.8, 1.331) (1591.5, 1.5) (3183.1, 1.6) (4774.6, 1.683) (6366.2, 1.741) (7957.7, 1.78) (15915.5, 1.905) (31831, 2.025) (47746.5, 2.085) (63662, 2.13) (79577.5, 2.165) (159155, 2.28) (318310, 2.485) (397887, 2.5851)} conductivity=2000000
  copper: permeability=0.999991 conductivity=58000000
  steel_1008_constant_u: permeability=4000 conductivity=2000000

design Maxwell2DDesign_rotation (Maxwell 2D, Transient, XY geometry, model units mm)
options: ComputeTransientInductance ModelDepth=StackLength
variables:
  CoreW = 60mm
  CoreH = 70mm
  RotorOffset = 22.5mm
  StatorBore = 12.5mm
  Airgap = 0.5mm
  StackLength = 20mm
  num_turns = 250
  InitialPosition = 0deg
  MachineRPM = 600rpm
  NumPoles = 2
  NumTorquePointsPerCycle = 100
  NumTorqueCycles = 0.995
  TimeStep = 120/(MachineRPM/1rpm*NumPoles)/NumTorquePointsPerCycle
  TimeStop = NumTorqueCycles*120/(MachineRPM/1rpm*NumPoles)
  I_dc = 3A
geometry:
  Core [steel_1008_constant_u] = rectangle(corner=(-CoreW/2, -CoreH/2, 0mm), x_size=CoreW, y_size=CoreH)
  Rectangle2 = rectangle(corner=(-15mm, -20mm, 0mm), x_size=30mm, y_size=40mm)
  Core.subtract(Rectangle2)
  Circle1 = circle(normal=Z, centre=(RotorOffset, 0mm, 0mm), radius=StatorBore)
  Core.subtract(Circle1)
  Rotor [steel_1008_constant_u, oriented by ObjectCS1] = circle(normal=Z, centre=(RotorOffset, 0mm, 0mm), radius=10mm)
  Rectangle3 = rectangle(corner=(-7.5mm+RotorOffset, -15mm, 0mm), x_size=15mm, y_size=30mm)
  Circle3 = circle(normal=Z, centre=(RotorOffset, 0mm, 0mm), radius=StatorBore-Airgap)
  Rectangle3.intersect(Circle3)
  Rotor.unite(Rectangle3)
  Coil1 [copper] = rectangle(corner=(-14.5mm, 16mm, 0mm), x_size=10mm, y_size=-30mm)
  Coil2 [copper] = rectangle(corner=(-40.5mm, 16mm, 0mm), x_size=10mm, y_size=-30mm)
  Region [vacuum] = region(percentage_offset: +X=20, -X=20, +Y=20, -Y=20, +Z=0, -Z=0)
  coordinate_system ObjectCS1 = object of Rotor: Origin=(22.5, 0, 0) xAxisPos=(22.5, -10, 0) yAxis{xDirection=2.9895442e-17 yDirection=1 zDirection=0}
  Rotor.rotate(axis=Z, angle=InitialPosition-90deg) in ObjectCS1
  Band [vacuum] = circle(normal=Z, centre=(0mm, 0mm, 0mm), radius=12.35mm) in ObjectCS1
  Polyline1 = polyline(z=0mm, xy in mm: (12.2, 0) (-12.199535, 0.10646373) (12.198142, -0.21291936), AngularArc from point 0 over 3 centre=(0mm, 0mm, 0mm) angle=359deg plane=XY) in ObjectCS1
motion:
  MotionSetup1: Band Move_Type=Rotate Coordinate_System=ObjectCS1 Axis=Z Is_Positive=true InitPos=0deg Angular_Velocity=MachineRPM Objects=Band
  Moving1: Moving Objects=[Rotor, Polyline1]
boundaries and excitations:
  VectorPotential1: Vector Potential Edges=Region.edge(all 4) Value=0
  Coil1: Coil Objects=Coil1 Conductor_number=num_turns Winding=Winding1 PolarityType=Negative
  Coil2: Coil Objects=Coil2 Conductor_number=num_turns Winding=Winding1 PolarityType=Positive
  Winding1: Winding Group Type=Current IsSolid=false Current=I_dc ParallelBranchesNum=1
mesh:
  CylindricalGap1: CylindricalGap Objects=Band
  initial mesh: GlobalSurfApproximation{CurvedSurfaceApproxChoice=UseSlider SliderMeshSettings=7} MeshMethod=AnsoftClassic
setups:
  Setup1: Transient NonlinearSolverResidual=0.0001 StopTime=TimeStop TimeStep=TimeStep SaveFieldsType="Every N Steps" N_Steps=1 Steps_From=0s Steps_To=TimeStop NumberSolveSteps=1 RangeStart=0s RangeEnd=0.1s InitialTimeStep=0.002s MinTimeStep=0.001s MaxTimeStep=0.003s TimeStepErrTolerance=0.0001
optimetrics:
  ParametricSetup1: Parametric InterpolationPoints=0 Sim._Setups=[Setup1]
    sweep InitialPosition: LIN 0deg 360deg 5deg
field plots:
  Flux_Lines2: A over Region on Setup1 : Transient at Time=-1
  Mag_B1: B over Coil1, Coil2, Core, Rotor, Region on Setup1 : Transient at Time=-1
  B_Vector1: B over Core, Rotor, Coil1, Coil2 on Setup1 : Transient at Time=-1
reports:
  Torque Plot 1: Moving1.Torque vs Moving1.Position on Setup1 : Transient
  Inductance: L(Winding1,Winding1) vs Moving1.Position on Setup1 : Transient
  Stored Energy (J): L(Winding1,Winding1)*I_dc^2/2 vs Moving1.Position on Setup1 : Transient
  Energy (J): avg(energy)*pi*(0.0122)^2*0.02 vs Time on Setup1 : Transient
  CoEnergy: avg(coEnergy) vs Time on Setup1 : Transient

design Maxwell2DDesign_fixed (Maxwell 2D, Transient, XY geometry, model units mm)
options: ComputeTransientInductance ModelDepth=StackLength
variables:
  CoreW = 60mm
  CoreH = 70mm
  RotorOffset = 22.5mm
  StatorBore = 12.5mm
  Airgap = 0.5mm
  StackLength = 20mm
  num_turns = 250
  InitialPosition = 90deg
  MachineRPM = 500rpm
  NumPoles = 2
  NumTorquePointsPerCycle = 100
  NumTorqueCycles = 0.5
  TimeStep = 120/(MachineRPM/1rpm*NumPoles)/NumTorquePointsPerCycle
  TimeStop = NumTorqueCycles*120/(MachineRPM/1rpm*NumPoles)
geometry:
  Core [steel_1008_constant_u] = rectangle(corner=(-CoreW/2, -CoreH/2, 0mm), x_size=CoreW, y_size=CoreH)
  Rectangle2 = rectangle(corner=(-15mm, -20mm, 0mm), x_size=30mm, y_size=40mm)
  Core.subtract(Rectangle2)
  Circle1 = circle(normal=Z, centre=(RotorOffset, 0mm, 0mm), radius=StatorBore)
  Core.subtract(Circle1)
  Rotor [steel_1008_constant_u, oriented by ObjectCS1] = circle(normal=Z, centre=(RotorOffset, 0mm, 0mm), radius=10mm)
  Rectangle3 = rectangle(corner=(-7.5mm+RotorOffset, -15mm, 0mm), x_size=15mm, y_size=30mm)
  Circle3 = circle(normal=Z, centre=(RotorOffset, 0mm, 0mm), radius=StatorBore-Airgap)
  Rectangle3.intersect(Circle3)
  Rotor.unite(Rectangle3)
  Coil1 [copper] = rectangle(corner=(-14.5mm, 16mm, 0mm), x_size=10mm, y_size=-30mm)
  Coil2 [copper] = rectangle(corner=(-40.5mm, 16mm, 0mm), x_size=10mm, y_size=-30mm)
  Region [vacuum] = region(percentage_offset: +X=20, -X=20, +Y=20, -Y=20, +Z=0, -Z=0)
  coordinate_system ObjectCS1 = object of Rotor: Origin=(22.5, 0, 0) xAxisPos=(32.5, 0, 0) yAxis{xDirection=2.9895442e-17 yDirection=1 zDirection=0}
  Rotor.rotate(axis=Z, angle=InitialPosition-90deg) in ObjectCS1
  Band [vacuum] = circle(normal=Z, centre=(0mm, 0mm, 0mm), radius=12.35mm) in ObjectCS1
  Polyline1 = polyline(z=0mm, xy in mm: (7.4, 9.8) (-1.7763568e-15, 12.280065) (-7.4, 9.8), AngularArc from point 0 over 3 centre=(0mm, 0mm, 0mm) angle=74.113056deg plane=XY) in ObjectCS1
  Polyline2 = polyline(z=0mm, xy in mm: (12.2, 0) (-12.199535, 0.10646373) (12.198142, -0.21291936), AngularArc from point 0 over 3 centre=(0mm, 0mm, 0mm) angle=359deg plane=XY) in ObjectCS1
  Polyline1_1 = Polyline1.duplicate_mirror(point=(0mm, 0mm, 0mm), normal=(0mm, -1mm, 0mm)) in ObjectCS1
boundaries and excitations:
  VectorPotential1: Vector Potential Edges=Region.edge(all 4) Value=0
  Coil1: Coil Objects=Coil1 Conductor_number=num_turns Winding=Winding1 PolarityType=Negative
  Coil2: Coil Objects=Coil2 Conductor_number=num_turns Winding=Winding1 PolarityType=Positive
  Winding1: Winding Group Type=Current IsSolid=false Current=3A ParallelBranchesNum=1
mesh:
  CylindricalGap1: CylindricalGap Objects=Band
  initial mesh: GlobalSurfApproximation{CurvedSurfaceApproxChoice=UseSlider SliderMeshSettings=7} MeshMethod=AnsoftClassic
setups:
  Setup1: Transient NonlinearSolverResidual=0.0001 StopTime=TimeStop TimeStep=TimeStep SaveFieldsType="Every N Steps" N_Steps=1 Steps_From=0s Steps_To=TimeStop NumberSolveSteps=1 RangeStart=0s RangeEnd=0.1s InitialTimeStep=0.002s MinTimeStep=0.001s MaxTimeStep=0.003s TimeStepErrTolerance=0.0001
optimetrics:
  ParametricSetup1: Parametric InterpolationPoints=0 Sim._Setups=[Setup1]
    sweep InitialPosition: LIN 0deg 360deg 5deg
field calculator expressions:
  BTang = Fundamental_Quantity(22) | Tangent | Dot
  Bradial = Fundamental_Quantity(22) | 2D_Normal | Dot
field plots:
  B_Vector1, Mag_B1: B over Core, Rotor, Coil1, Coil2, Band on Setup1 : Transient at Time=-1
reports:
  Inductance: L(Winding1,Winding1) vs Time on Setup1 : Transient [InitialPosition=0deg,45deg,90deg]
  Energy Cal: energy vs Distance on Setup1 : Transient [Time=0ns InitialPosition=0deg,45deg,90deg]
  Energy (J): L(Winding1,Winding1)*3^2/2 vs Time on Setup1 : Transient [InitialPosition=0deg,45deg,90deg]
  Stored Energy (J): energy*pi*12.2^2*20/1000000000 vs Distance on Setup1 : Transient [Time=0ns InitialPosition=0deg,45deg,90deg]
  Calculator Expressions Plot 1: energy*2*9.3518930112060965122555968233464e-6 vs Distance on Setup1 : Transient [Time=0ns InitialPosition=0deg,45deg,90deg]
  Calculator Expressions Plot 2: energy*2 vs Distance on Setup1 : Transient [Time=0ns InitialPosition=0deg,45deg,90deg]

design Maxwell2DDesign_rotation_positive torque1 (Maxwell 2D, Transient, XY geometry, model units mm)
options: ComputeTransientInductance ModelDepth=StackLength
variables:
  CoreW = 60mm
  CoreH = 70mm
  RotorOffset = 22.5mm
  StatorBore = 12.5mm
  Airgap = 0.5mm
  StackLength = 20mm
  num_turns = 250
  InitialPosition = 0deg
  MachineRPM = 500rpm
  NumPoles = 2
  NumTorquePointsPerCycle = 80
  NumTorqueCycles = 0.996
  TimeStep = 120/(MachineRPM/1rpm*NumPoles)/NumTorquePointsPerCycle
  TimeStop = NumTorqueCycles*120/(MachineRPM/1rpm*NumPoles)
datasets:
  ds_current: units ms, A: (0, 0) (0.005, 3) (0.01, 3) (0.015, 3) (0.02, 3) (0.025, 0) (0.03, 0) (0.035, 0)
geometry:
  Core [steel_1008_constant_u] = rectangle(corner=(-CoreW/2, -CoreH/2, 0mm), x_size=CoreW, y_size=CoreH)
  Rectangle2 = rectangle(corner=(-15mm, -20mm, 0mm), x_size=30mm, y_size=40mm)
  Core.subtract(Rectangle2)
  Circle1 = circle(normal=Z, centre=(RotorOffset, 0mm, 0mm), radius=StatorBore)
  Core.subtract(Circle1)
  Rotor [steel_1008_constant_u, oriented by ObjectCS1] = circle(normal=Z, centre=(RotorOffset, 0mm, 0mm), radius=10mm)
  Rectangle3 = rectangle(corner=(-7.5mm+RotorOffset, -15mm, 0mm), x_size=15mm, y_size=30mm)
  Circle3 = circle(normal=Z, centre=(RotorOffset, 0mm, 0mm), radius=StatorBore-Airgap)
  Rectangle3.intersect(Circle3)
  Rotor.unite(Rectangle3)
  Coil1 [copper] = rectangle(corner=(-14.5mm, 16mm, 0mm), x_size=10mm, y_size=-30mm)
  Coil2 [copper] = rectangle(corner=(-40.5mm, 16mm, 0mm), x_size=10mm, y_size=-30mm)
  Region [vacuum] = region(percentage_offset: +X=20, -X=20, +Y=20, -Y=20, +Z=0, -Z=0)
  coordinate_system ObjectCS1 = object of Rotor: Origin=(22.5, 0, 0) xAxisPos=(22.5, -10, 0) yAxis{xDirection=2.9895442e-17 yDirection=1 zDirection=0}
  Rotor.rotate(axis=Z, angle=InitialPosition-90deg) in ObjectCS1
  Band [vacuum] = circle(normal=Z, centre=(0mm, 0mm, 0mm), radius=12.35mm) in ObjectCS1
motion:
  MotionSetup1: Band Move_Type=Rotate Coordinate_System=ObjectCS1 Axis=Z Is_Positive=true InitPos=0deg Angular_Velocity=MachineRPM Objects=Band
  Moving1: Moving Objects=Rotor
boundaries and excitations:
  VectorPotential1: Vector Potential Edges=Region.edge(all 4) Value=0
  Coil1: Coil Objects=Coil1 Conductor_number=num_turns Winding=Winding1 PolarityType=Negative
  Coil2: Coil Objects=Coil2 Conductor_number=num_turns Winding=Winding1 PolarityType=Positive
  Winding1: Winding Group Type=External IsSolid=false Current=0 ParallelBranchesNum=1
  external circuit: "* Design: Project1_2_ckt2"
mesh:
  CylindricalGap1: CylindricalGap Objects=Band
  initial mesh: GlobalSurfApproximation{CurvedSurfaceApproxChoice=UseSlider SliderMeshSettings=7} MeshMethod=AnsoftClassic
setups:
  Setup1: Transient NonlinearSolverResidual=0.0001 StopTime=TimeStop TimeStep=TimeStep SaveFieldsType="Every N Steps" N_Steps=1 Steps_From=0s Steps_To=TimeStop NumberSolveSteps=1 RangeStart=0s RangeEnd=0.1s InitialTimeStep=0.002s MinTimeStep=0.001s MaxTimeStep=0.003s TimeStepErrTolerance=0.0001
field plots:
  Flux_Lines2: A over Region on Setup1 : Transient at Time=-1
  Mag_B1: B over Coil1, Coil2, Core, Rotor, Region on Setup1 : Transient at Time=-1
  B_Vector1: B over Core, Rotor, Coil1, Coil2 on Setup1 : Transient at Time=-1
reports:
  Torque Plot 1: Moving1.Torque, BranchCurrent(VWindingCurrent) vs Moving1.Position on Setup1 : Transient
  Inductance: L(Winding1,Winding1) vs Moving1.Position on Setup1 : Transient
  NodeVoltage Plot 1: NodeVoltage(IVoltmeter25), NodeVoltage(IVoltmeter26) vs Time on Setup1 : Transient

design Project1_2_ckt2 (Maxwell Circuit)
variables:
  PulseWidth = 85
  PulseInitial_delay = 2
components:
  Winding_2 = Winding(Name=Winding1)
  IPulse_22 = IPulse(Type=POS I2=3A Pw=PulseWidth Period=180 Tr=1 Tf=1 Td=PulseInitial_delay)
  Res_24 = Res(R=2.3ohm)
  VoltmeterG_25 = VoltmeterG()
  VoltmeterG_26 = VoltmeterG()
  Ammeter_27 = Ammeter(Name=WindingCurrent)
nets:
  0: IPulse_22.0, Winding_2.1
  net_1: Res_24.0, Winding_2.0, VoltmeterG_26.0
  net_2: IPulse_22.1, VoltmeterG_25.0, Ammeter_27.0
  net_3: Res_24.1, Ammeter_27.1
