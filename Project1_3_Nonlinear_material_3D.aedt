# Ansys Electronics Desktop project, version 2022.1
materials:
  vacuum: permittivity=1
  steel_1008: permeability{HUnit=A_per_meter BUnit=tesla curve (0, 0) (159.2, 0.2402) (318.3, 0.8654) (477.5, 1.1106) (636.6, 1.2458) (795.8, 1.331) (1591.5, 1.5) (3183.1, 1.6) (4774.6, 1.683) (6366.2, 1.741) (7957.7, 1.78) (15915.5, 1.905) (31831, 2.025) (47746.5, 2.085) (63662, 2.13) (79577.5, 2.165) (159155, 2.28) (318310, 2.485) (397887, 2.5851)} conductivity=2000000
  copper: permeability=0.999991 conductivity=58000000
  steel_1008_constant_u: permeability=1200 conductivity=2000000

design Maxwell3DDesign1_fixed (Maxwell 3D, Transient, model units mm)
options: ComputeTransientInductance
variables:
  RotorOffset = 22.5mm
  StatorBore = 12.5mm
  CoreW = 60mm
  CoreH = 70mm
  InitialPosition = 90deg
  Airgap = 0.5mm
  num_turns = 10
  ZLength = 20mm
  NumTorqueCycles = 0.5
  MachineRPM = 600rpm
  NumPoles = 2
  TimeStop = NumTorqueCycles*120/(MachineRPM/1rpm*NumPoles)
  NumTorquePointsPerCycle = 100
  TimeStep = 120/(MachineRPM/1rpm*NumPoles)/NumTorquePointsPerCycle
  I_dc = 3A
geometry:
  Core [steel_1008] = rectangle(corner=(-CoreW/2, -CoreH/2, 0mm), x_size=CoreW, y_size=CoreH)
  Rectangle2 = rectangle(corner=(-15mm, -20mm, 0mm), x_size=30mm, y_size=40mm)
  Core.subtract(Rectangle2)
  Circle1 = circle(normal=Z, centre=(RotorOffset, 0mm, 0mm), radius=StatorBore)
  Core.subtract(Circle1)
  Rotor [steel_1008, oriented by ObjectCS1] = circle(normal=Z, centre=(RotorOffset, 0mm, 0mm), radius=10mm)
  Rectangle3 = rectangle(corner=(-7.5mm+RotorOffset, -15mm, 0mm), x_size=15mm, y_size=30mm)
  Circle3 = circle(normal=Z, centre=(RotorOffset, 0mm, 0mm), radius=StatorBore-Airgap)
  Rectangle3.intersect(Circle3)
  Rotor.unite(Rectangle3)
  Region [vacuum] = region(percentage_offset: +X=20, -X=20, +Y=20, -Y=20, +Z=0, -Z=0)
  coordinate_system ObjectCS1 = object of Rotor: Origin=(22.5, 0, -10) xAxisPos=(32.5, 0, -10) yAxis{xDirection=2.9895442e-17 yDirection=1 zDirection=0}
  Rotor.rotate(axis=Z, angle=InitialPosition-90deg) in ObjectCS1
  Band [vacuum] = circle(normal=Z, centre=(0mm, 0mm, 0mm), radius=12.35mm) in ObjectCS1
  [Core, Rotor, Band].sweep_along_vector((0meter, 0meter, ZLength))
  TransCoil1 [copper] = user_primitive(RMxprt/TransCoil.dll, DistLeg=100mm, CoilType=2, WidthIn=23mm, DepthIn=28mm, RadiusIn=14mm, ThickCoil=10mm, HighCoil=38mm, Layers=25, GapLayer=0.2mm, InfoCore=1)
  TransCoil1.rotate(axis=X, angle=90deg)
  TransCoil1.move(-22mm, 0mm, 0mm)
  [Core, Rotor, Band].move(0mm, 0mm, -10mm)
  TransCoil1_Separate1..TransCoil1_Separate24 [copper] = TransCoil1.separate_bodies()
  TransCoil1_Section1 [copper] = TransCoil1.section(plane=XY)
  TransCoil1_Separate1_Section1 [copper] = TransCoil1_Separate1.section(plane=XY)
  TransCoil1_Separate2_Section1 [copper] = TransCoil1_Separate2.section(plane=XY)
  TransCoil1_Separate3_Section1 [copper] = TransCoil1_Separate3.section(plane=XY)
  TransCoil1_Separate4_Section1 [copper] = TransCoil1_Separate4.section(plane=XY)
  TransCoil1_Separate5_Section1 [copper] = TransCoil1_Separate5.section(plane=XY)
  TransCoil1_Separate6_Section1 [copper] = TransCoil1_Separate6.section(plane=XY)
  TransCoil1_Separate7_Section1 [copper] = TransCoil1_Separate7.section(plane=XY)
  TransCoil1_Separate8_Section1 [copper] = TransCoil1_Separate8.section(plane=XY)
  TransCoil1_Separate9_Section1 [copper] = TransCoil1_Separate9.section(plane=XY)
  TransCoil1_Separate10_Section1 [copper] = TransCoil1_Separate10.section(plane=XY)
  TransCoil1_Separate11_Section1 [copper] = TransCoil1_Separate11.section(plane=XY)
  TransCoil1_Separate12_Section1 [copper] = TransCoil1_Separate12.section(plane=XY)
  TransCoil1_Separate13_Section1 [copper] = TransCoil1_Separate13.section(plane=XY)
  TransCoil1_Separate14_Section1 [copper] = TransCoil1_Separate14.section(plane=XY)
  TransCoil1_Separate15_Section1 [copper] = TransCoil1_Separate15.section(plane=XY)
  TransCoil1_Separate16_Section1 [copper] = TransCoil1_Separate16.section(plane=XY)
  TransCoil1_Separate17_Section1 [copper] = TransCoil1_Separate17.section(plane=XY)
  TransCoil1_Separate18_Section1 [copper] = TransCoil1_Separate18.section(plane=XY)
  TransCoil1_Separate19_Section1 [copper] = TransCoil1_Separate19.section(plane=XY)
  TransCoil1_Separate20_Section1 [copper] = TransCoil1_Separate20.section(plane=XY)
  TransCoil1_Separate21_Section1 [copper] = TransCoil1_Separate21.section(plane=XY)
  TransCoil1_Separate22_Section1 [copper] = TransCoil1_Separate22.section(plane=XY)
  TransCoil1_Separate23_Section1 [copper] = TransCoil1_Separate23.section(plane=XY)
  TransCoil1_Separate24_Section1 [copper] = TransCoil1_Separate24.section(plane=XY)
  TransCoil1_Section1.separate_bodies()
  TransCoil1_Separate1_Section1.separate_bodies()
  TransCoil1_Separate2_Section1.separate_bodies()
  TransCoil1_Separate3_Section1.separate_bodies()
  TransCoil1_Separate4_Section1.separate_bodies()
  TransCoil1_Separate5_Section1.separate_bodies()
  TransCoil1_Separate6_Section1.separate_bodies()
  TransCoil1_Separate7_Section1.separate_bodies()
  TransCoil1_Separate8_Section1.separate_bodies()
  TransCoil1_Separate9_Section1.separate_bodies()
  TransCoil1_Separate10_Section1.separate_bodies()
  TransCoil1_Separate11_Section1.separate_bodies()
  TransCoil1_Separate12_Section1.separate_bodies()
  TransCoil1_Separate13_Section1.separate_bodies()
  TransCoil1_Separate14_Section1.separate_bodies()
  TransCoil1_Separate15_Section1.separate_bodies()
  TransCoil1_Separate16_Section1.separate_bodies()
  TransCoil1_Separate17_Section1.separate_bodies()
  TransCoil1_Separate18_Section1.separate_bodies()
  TransCoil1_Separate19_Section1.separate_bodies()
  TransCoil1_Separate20_Section1.separate_bodies()
  TransCoil1_Separate21_Section1.separate_bodies()
  TransCoil1_Separate22_Section1.separate_bodies()
  TransCoil1_Separate23_Section1.separate_bodies()
  TransCoil1_Separate24_Section1.separate_bodies()
boundaries and excitations:
  CoilTerminal_1: Coil Terminal Objects=TransCoil1_Section1 Conductor_number=num_turns Winding=Winding1 Point_out_of_terminal=false
  CoilTerminal_2: Coil Terminal Objects=TransCoil1_Separate1_Section1 Conductor_number=num_turns Winding=Winding1 Point_out_of_terminal=false
  CoilTerminal_3: Coil Terminal Objects=TransCoil1_Separate2_Section1 Conductor_number=num_turns Winding=Winding1 Point_out_of_terminal=false
  CoilTerminal_4: Coil Terminal Objects=TransCoil1_Separate3_Section1 Conductor_number=num_turns Winding=Winding1 Point_out_of_terminal=false
  CoilTerminal_5: Coil Terminal Objects=TransCoil1_Separate4_Section1 Conductor_number=num_turns Winding=Winding1 Point_out_of_terminal=false
  CoilTerminal_6: Coil Terminal Objects=TransCoil1_Separate5_Section1 Conductor_number=num_turns Winding=Winding1 Point_out_of_terminal=false
  CoilTerminal_7: Coil Terminal Objects=TransCoil1_Separate6_Section1 Conductor_number=num_turns Winding=Winding1 Point_out_of_terminal=false
  CoilTerminal_8: Coil Terminal Objects=TransCoil1_Separate7_Section1 Conductor_number=num_turns Winding=Winding1 Point_out_of_terminal=false
  CoilTerminal_9: Coil Terminal Objects=TransCoil1_Separate8_Section1 Conductor_number=num_turns Winding=Winding1 Point_out_of_terminal=false
  CoilTerminal_10: Coil Terminal Objects=TransCoil1_Separate9_Section1 Conductor_number=num_turns Winding=Winding1 Point_out_of_terminal=false
  CoilTerminal_11: Coil Terminal Objects=TransCoil1_Separate10_Section1 Conductor_number=num_turns Winding=Winding1 Point_out_of_terminal=false
  CoilTerminal_12: Coil Terminal Objects=TransCoil1_Separate11_Section1 Conductor_number=num_turns Winding=Winding1 Point_out_of_terminal=false
  CoilTerminal_13: Coil Terminal Objects=TransCoil1_Separate12_Section1 Conductor_number=num_turns Winding=Winding1 Point_out_of_terminal=false
  CoilTerminal_14: Coil Terminal Objects=TransCoil1_Separate13_Section1 Conductor_number=num_turns Winding=Winding1 Point_out_of_terminal=false
  CoilTerminal_15: Coil Terminal Objects=TransCoil1_Separate14_Section1 Conductor_number=num_turns Winding=Winding1 Point_out_of_terminal=false
  CoilTerminal_16: Coil Terminal Objects=TransCoil1_Separate15_Section1 Conductor_number=num_turns Winding=Winding1 Point_out_of_terminal=false
  CoilTerminal_17: Coil Terminal Objects=TransCoil1_Separate16_Section1 Conductor_number=num_turns Winding=Winding1 Point_out_of_terminal=false
  CoilTerminal_18: Coil Terminal Objects=TransCoil1_Separate17_Section1 Conductor_number=num_turns Winding=Winding1 Point_out_of_terminal=false
  CoilTerminal_19: Coil Terminal Objects=TransCoil1_Separate18_Section1 Conductor_number=num_turns Winding=Winding1 Point_out_of_terminal=false
  CoilTerminal_20: Coil Terminal Objects=TransCoil1_Separate19_Section1 Conductor_number=num_turns Winding=Winding1 Point_out_of_terminal=false
  CoilTerminal_21: Coil Terminal Objects=TransCoil1_Separate20_Section1 Conductor_number=num_turns Winding=Winding1 Point_out_of_terminal=false
  CoilTerminal_22: Coil Terminal Objects=TransCoil1_Separate21_Section1 Conductor_number=num_turns Winding=Winding1 Point_out_of_terminal=false
  CoilTerminal_23: Coil Terminal Objects=TransCoil1_Separate22_Section1 Conductor_number=num_turns Winding=Winding1 Point_out_of_terminal=false
  CoilTerminal_24: Coil Terminal Objects=TransCoil1_Separate23_Section1 Conductor_number=num_turns Winding=Winding1 Point_out_of_terminal=false
  CoilTerminal_25: Coil Terminal Objects=TransCoil1_Separate24_Section1 Conductor_number=num_turns Winding=Winding1 Point_out_of_terminal=false
  Winding1: Winding Group Type=Current IsSolid=false Current=I_dc ParallelBranchesNum=1
mesh:
  initial mesh: GlobalCurvilinear{Apply}
setups:
  Setup1: Transient NonlinearSolverResidual=0.005 ScalarPotential="Second Order" StopTime=TimeStop TimeStep=TimeStep
reports:
  Winding Plot 1: L(Winding1,Winding1) vs Time on Setup1 : Transient [InitialPosition=0deg,45deg,90deg]
   Plot 1: 62500/L(Winding1,Winding1) vs Time on Setup1 : Transient [InitialPosition=0deg,45deg,90deg]
  Energy (J): L(Winding1,Winding1)*3^2/2 vs Time on Setup1 : Transient [InitialPosition=0deg,45deg,90deg]

design Maxwell3DDesign1_rotation (Maxwell 3D, Transient, model units mm)
options: ComputeTransientInductance
variables:
  RotorOffset = 22.5mm
  StatorBore = 12.5mm
  CoreW = 60mm
  CoreH = 70mm
  InitialPosition = 0deg
  Airgap = 0.5mm
  num_turns = 10
  ZLength = 20mm
  NumTorqueCycles = 0.995
  MachineRPM = 600rpm
  NumPoles = 2
  TimeStop = NumTorqueCycles*120/(MachineRPM/1rpm*NumPoles)
  NumTorquePointsPerCycle = 100
  TimeStep = 120/(MachineRPM/1rpm*NumPoles)/NumTorquePointsPerCycle
  I_dc = 3A
geometry:
  Core [steel_1008] = rectangle(corner=(-CoreW/2, -CoreH/2, 0mm), x_size=CoreW, y_size=CoreH)
  Rectangle2 = rectangle(corner=(-15mm, -20mm, 0mm), x_size=30mm, y_size=40mm)
  Core.subtract(Rectangle2)
  Circle1 = circle(normal=Z, centre=(RotorOffset, 0mm, 0mm), radius=StatorBore)
  Core.subtract(Circle1)
  Rotor [steel_1008, oriented by ObjectCS1] = circle(normal=Z, centre=(RotorOffset, 0mm, 0mm), radius=10mm)
  Rectangle3 = rectangle(corner=(-7.5mm+RotorOffset, -15mm, 0mm), x_size=15mm, y_size=30mm)
  Circle3 = circle(normal=Z, centre=(RotorOffset, 0mm, 0mm), radius=StatorBore-Airgap)
  Rectangle3.intersect(Circle3)
  Rotor.unite(Rectangle3)
  Region [vacuum] = region(percentage_offset: +X=20, -X=20, +Y=20, -Y=20, +Z=0, -Z=0)
  coordinate_system ObjectCS1 = object of Rotor: Origin=(22.5, 0, -10) xAxisPos=(22.5, -10, -10) yAxis{xDirection=2.9895442e-17 yDirection=1 zDirection=0}
  Rotor.rotate(axis=Z, angle=InitialPosition-90deg) in ObjectCS1
  Band [vacuum] = circle(normal=Z, centre=(0mm, 0mm, 0mm), radius=12.35mm) in ObjectCS1
  [Core, Rotor].sweep_along_vector((0meter, 0meter, ZLength))
  Band.sweep_along_vector((0meter, 0meter, 30mm))
  TransCoil1 [copper] = user_primitive(RMxprt/TransCoil.dll, DistLeg=100mm, CoilType=2, WidthIn=23mm, DepthIn=28mm, RadiusIn=14mm, ThickCoil=10mm, HighCoil=38mm, Layers=25, GapLayer=0.2mm, InfoCore=1)
  TransCoil1.rotate(axis=X, angle=90deg)
  TransCoil1.move(-22mm, 0mm, 0mm)
  [Core, Rotor].move(0mm, 0mm, -10mm)
  Band.move(0mm, 0mm, -15mm)
  TransCoil1_Separate1..TransCoil1_Separate24 [copper] = TransCoil1.separate_bodies()
  TransCoil1_Section1 [copper] = TransCoil1.section(plane=XY)
  TransCoil1_Separate1_Section1 [copper] = TransCoil1_Separate1.section(plane=XY)
  TransCoil1_Separate2_Section1 [copper] = TransCoil1_Separate2.section(plane=XY)
  TransCoil1_Separate3_Section1 [copper] = TransCoil1_Separate3.section(plane=XY)
  TransCoil1_Separate4_Section1 [copper] = TransCoil1_Separate4.section(plane=XY)
  TransCoil1_Separate5_Section1 [copper] = TransCoil1_Separate5.section(plane=XY)
  TransCoil1_Separate6_Section1 [copper] = TransCoil1_Separate6.section(plane=XY)
  TransCoil1_Separate7_Section1 [copper] = TransCoil1_Separate7.section(plane=XY)
  TransCoil1_Separate8_Section1 [copper] = TransCoil1_Separate8.section(plane=XY)
  TransCoil1_Separate9_Section1 [copper] = TransCoil1_Separate9.section(plane=XY)
  TransCoil1_Separate10_Section1 [copper] = TransCoil1_Separate10.section(plane=XY)
  TransCoil1_Separate11_Section1 [copper] = TransCoil1_Separate11.section(plane=XY)
  TransCoil1_Separate12_Section1 [copper] = TransCoil1_Separate12.section(plane=XY)
  TransCoil1_Separate13_Section1 [copper] = TransCoil1_Separate13.section(plane=XY)
  TransCoil1_Separate14_Section1 [copper] = TransCoil1_Separate14.section(plane=XY)
  TransCoil1_Separate15_Section1 [copper] = TransCoil1_Separate15.section(plane=XY)
  TransCoil1_Separate16_Section1 [copper] = TransCoil1_Separate16.section(plane=XY)
  TransCoil1_Separate17_Section1 [copper] = TransCoil1_Separate17.section(plane=XY)
  TransCoil1_Separate18_Section1 [copper] = TransCoil1_Separate18.section(plane=XY)
  TransCoil1_Separate19_Section1 [copper] = TransCoil1_Separate19.section(plane=XY)
  TransCoil1_Separate20_Section1 [copper] = TransCoil1_Separate20.section(plane=XY)
  TransCoil1_Separate21_Section1 [copper] = TransCoil1_Separate21.section(plane=XY)
  TransCoil1_Separate22_Section1 [copper] = TransCoil1_Separate22.section(plane=XY)
  TransCoil1_Separate23_Section1 [copper] = TransCoil1_Separate23.section(plane=XY)
  TransCoil1_Separate24_Section1 [copper] = TransCoil1_Separate24.section(plane=XY)
  TransCoil1_Section1.separate_bodies()
  TransCoil1_Separate1_Section1.separate_bodies()
  TransCoil1_Separate2_Section1.separate_bodies()
  TransCoil1_Separate3_Section1.separate_bodies()
  TransCoil1_Separate4_Section1.separate_bodies()
  TransCoil1_Separate5_Section1.separate_bodies()
  TransCoil1_Separate6_Section1.separate_bodies()
  TransCoil1_Separate7_Section1.separate_bodies()
  TransCoil1_Separate8_Section1.separate_bodies()
  TransCoil1_Separate9_Section1.separate_bodies()
  TransCoil1_Separate10_Section1.separate_bodies()
  TransCoil1_Separate11_Section1.separate_bodies()
  TransCoil1_Separate12_Section1.separate_bodies()
  TransCoil1_Separate13_Section1.separate_bodies()
  TransCoil1_Separate14_Section1.separate_bodies()
  TransCoil1_Separate15_Section1.separate_bodies()
  TransCoil1_Separate16_Section1.separate_bodies()
  TransCoil1_Separate17_Section1.separate_bodies()
  TransCoil1_Separate18_Section1.separate_bodies()
  TransCoil1_Separate19_Section1.separate_bodies()
  TransCoil1_Separate20_Section1.separate_bodies()
  TransCoil1_Separate21_Section1.separate_bodies()
  TransCoil1_Separate22_Section1.separate_bodies()
  TransCoil1_Separate23_Section1.separate_bodies()
  TransCoil1_Separate24_Section1.separate_bodies()
motion:
  MotionSetup1: Band Move_Type=Rotate Coordinate_System=ObjectCS1 Axis=Z Is_Positive=true InitPos=0deg Angular_Velocity=MachineRPM Objects=Band
  Moving1: Moving Objects=Rotor
boundaries and excitations:
  CoilTerminal_1: Coil Terminal Objects=TransCoil1_Section1 Conductor_number=num_turns Winding=Winding1 Point_out_of_terminal=false
  CoilTerminal_2: Coil Terminal Objects=TransCoil1_Separate1_Section1 Conductor_number=num_turns Winding=Winding1 Point_out_of_terminal=false
  CoilTerminal_3: Coil Terminal Objects=TransCoil1_Separate2_Section1 Conductor_number=num_turns Winding=Winding1 Point_out_of_terminal=false
  CoilTerminal_4: Coil Terminal Objects=TransCoil1_Separate3_Section1 Conductor_number=num_turns Winding=Winding1 Point_out_of_terminal=false
  CoilTerminal_5: Coil Terminal Objects=TransCoil1_Separate4_Section1 Conductor_number=num_turns Winding=Winding1 Point_out_of_terminal=false
  CoilTerminal_6: Coil Terminal Objects=TransCoil1_Separate5_Section1 Conductor_number=num_turns Winding=Winding1 Point_out_of_terminal=false
  CoilTerminal_7: Coil Terminal Objects=TransCoil1_Separate6_Section1 Conductor_number=num_turns Winding=Winding1 Point_out_of_terminal=false
  CoilTerminal_8: Coil Terminal Objects=TransCoil1_Separate7_Section1 Conductor_number=num_turns Winding=Winding1 Point_out_of_terminal=false
  CoilTerminal_9: Coil Terminal Objects=TransCoil1_Separate8_Section1 Conductor_number=num_turns Winding=Winding1 Point_out_of_terminal=false
  CoilTerminal_10: Coil Terminal Objects=TransCoil1_Separate9_Section1 Conductor_number=num_turns Winding=Winding1 Point_out_of_terminal=false
  CoilTerminal_11: Coil Terminal Objects=TransCoil1_Separate10_Section1 Conductor_number=num_turns Winding=Winding1 Point_out_of_terminal=false
  CoilTerminal_12: Coil Terminal Objects=TransCoil1_Separate11_Section1 Conductor_number=num_turns Winding=Winding1 Point_out_of_terminal=false
  CoilTerminal_13: Coil Terminal Objects=TransCoil1_Separate12_Section1 Conductor_number=num_turns Winding=Winding1 Point_out_of_terminal=false
  CoilTerminal_14: Coil Terminal Objects=TransCoil1_Separate13_Section1 Conductor_number=num_turns Winding=Winding1 Point_out_of_terminal=false
  CoilTerminal_15: Coil Terminal Objects=TransCoil1_Separate14_Section1 Conductor_number=num_turns Winding=Winding1 Point_out_of_terminal=false
  CoilTerminal_16: Coil Terminal Objects=TransCoil1_Separate15_Section1 Conductor_number=num_turns Winding=Winding1 Point_out_of_terminal=false
  CoilTerminal_17: Coil Terminal Objects=TransCoil1_Separate16_Section1 Conductor_number=num_turns Winding=Winding1 Point_out_of_terminal=false
  CoilTerminal_18: Coil Terminal Objects=TransCoil1_Separate17_Section1 Conductor_number=num_turns Winding=Winding1 Point_out_of_terminal=false
  CoilTerminal_19: Coil Terminal Objects=TransCoil1_Separate18_Section1 Conductor_number=num_turns Winding=Winding1 Point_out_of_terminal=false
  CoilTerminal_20: Coil Terminal Objects=TransCoil1_Separate19_Section1 Conductor_number=num_turns Winding=Winding1 Point_out_of_terminal=false
  CoilTerminal_21: Coil Terminal Objects=TransCoil1_Separate20_Section1 Conductor_number=num_turns Winding=Winding1 Point_out_of_terminal=false
  CoilTerminal_22: Coil Terminal Objects=TransCoil1_Separate21_Section1 Conductor_number=num_turns Winding=Winding1 Point_out_of_terminal=false
  CoilTerminal_23: Coil Terminal Objects=TransCoil1_Separate22_Section1 Conductor_number=num_turns Winding=Winding1 Point_out_of_terminal=false
  CoilTerminal_24: Coil Terminal Objects=TransCoil1_Separate23_Section1 Conductor_number=num_turns Winding=Winding1 Point_out_of_terminal=false
  CoilTerminal_25: Coil Terminal Objects=TransCoil1_Separate24_Section1 Conductor_number=num_turns Winding=Winding1 Point_out_of_terminal=false
  Winding1: Winding Group Type=Current IsSolid=false Current=I_dc ParallelBranchesNum=1
mesh:
  CylindricalGap1: CylindricalGap BandMappingAngle=3deg MovingSideLayers=1 StaticSideLayers=1 Objects=Band
  initial mesh: GlobalCurvilinear{Apply}
setups:
  Setup1: Transient NonlinearSolverResidual=0.005 ScalarPotential="Second Order" StopTime=TimeStop TimeStep=TimeStep
field plots:
  coEnergy1: Energy on Setup1 : Transient at Time=0.0995s
reports:
  Torque Plot 1: Moving1.Torque vs Moving1.Position on Setup1 : Transient
  Inductance: L(Winding1,Winding1) vs Time on Setup1 : Transient

design Project1_2_ckt1 (Maxwell Circuit)
components:
  Winding_2 = Winding(Name=Winding1)
  IPulse_22 = IPulse(Type=TIME I2=3A Pw=0.03 Period=0.1 Tr=0.001 Tf=0.001 Td=0.003)
  Res_24 = Res(R=3ohm)
  VoltmeterG_25 = VoltmeterG()
  VoltmeterG_26 = VoltmeterG()
  Ammeter_27 = Ammeter(Name=WindingCurrent)
nets:
  0: Winding_2.1, IPulse_22.0
  net_1: Winding_2.0, VoltmeterG_26.0, Res_24.0
  net_2: Ammeter_27.0, VoltmeterG_25.0, IPulse_22.1
  net_3: Ammeter_27.1, Res_24.1

design Project1_2_ckt2 (Maxwell Circuit)
variables:
  PulseWidth = 75
  PulseInitial_delay = 2
components:
  Winding_2 = Winding(Name=Winding1)
  IPulse_22 = IPulse(Type=POS I2=3A Pw=PulseWidth Period=180 Tr=1 Tf=1 Td=PulseInitial_delay)
  Res_24 = Res(R=2.3ohm)
  VoltmeterG_25 = VoltmeterG()
  VoltmeterG_26 = VoltmeterG()
  Ammeter_27 = Ammeter(Name=WindingCurrent)
nets:
  0: Winding_2.1, IPulse_22.0
  net_1: VoltmeterG_26.0, Res_24.0, Winding_2.0
  net_2: Ammeter_27.0, VoltmeterG_25.0, IPulse_22.1
  net_3: Ammeter_27.1, Res_24.1
